VCVS (E): v(x) = 5 v(in), then R-C low-pass (tau = 1 ms) to v(out)
V1 in 0 DC 1 AC 1 PULSE(0 1 0 10u 10u 3m 6m)
E1 x 0 in 0 5
R1 x out 1k
C1 out 0 1u
.op
.dc V1 -2 2 1
.ac dec 10 10 100k
.tran 10u 5m
.end
