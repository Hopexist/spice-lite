Inverting amplifier, gain -R2/R1 = -10 (the op-amp is a 1e6-gain VCVS); .op, .ac and a .dc sweep
V1 in 0 DC 1 AC 1
R1 in inn 1k
R2 inn out 10k
E1 out 0 0 inn 1e6
.op
.dc V1 -1 1 0.5
.ac dec 10 10 1meg
.end
