NMOS output characteristics: Id vs Vds for Vgs = 1.5, 2, 2.5, 3 V (VTO 1, KP 100u, W/L = 10, LAMBDA 0.02)
Vds d 0 DC 0
Vgs g 0 DC 2.5
M1 d g 0 0 nm W=10u L=1u
.model nm NMOS (LEVEL=1 VTO=1 KP=100u LAMBDA=0.02)
.dc Vds 0 5 0.05
.end
