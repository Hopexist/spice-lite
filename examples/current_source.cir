Current source into a resistor pair: v(a) = 2mA * (1k||2k) = 1.3333 V
I1 0 a 2m
R1 a 0 1k
R2 a 0 2k
.end
