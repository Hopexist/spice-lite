Half-wave rectifier with a 10 uF filter capacitor: peak ~ 5 V - 0.7 V, ripple ~ I/(f C) ~ 0.4 V
V1 in 0 DC 0 SIN(0 5 1k)
D1 in out dm
C1 out 0 10u
R1 out 0 1k
.model dm D(IS=1e-14 N=1 RS=1)
.tran 2u 5m
.end
