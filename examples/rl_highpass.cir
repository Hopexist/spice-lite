RL highpass (output across L), corner R/(2 pi L) = 1 kHz: -3.01 dB and +45 degrees there
V1 in 0 DC 0 AC 1
R1 in out 1k
L1 out 0 159.154943m
.ac dec 20 10 100k
.end
