RC pulse response, tau = R C = 1 ms (10 us edges, aligned to the 10 us step)
V1 in 0 DC 0 PULSE(0 1 0 10u 10u 2.5m 5m)
R1 in out 1k
C1 out 0 1u
.tran 10u 5m
.end
